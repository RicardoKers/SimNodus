* S2 rlc_ring: 5 V step into series R = 50 Ohm, L = 10 mH, C = 100 nF (underdamped)
* probes: out l1#branch
V1 in 0 DC 5
R1 in a 50
L1 a out 10m IC=0
C1 out 0 100n IC=0
.options reltol=1e-6 abstol=1e-12 vntol=1e-9
.tran 1u 5m 0 1u uic
.end
