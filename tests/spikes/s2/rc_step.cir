* S2 rc_step: 3.3 V step into 1 kOhm / 1 uF, tau = 1 ms
* probes: out
V1 in 0 DC 3.3
R1 in out 1k
C1 out 0 1u IC=0
.options reltol=1e-6 abstol=1e-12 vntol=1e-9
.tran 1u 5m 0 1u uic
.end
