* S2 bjt_led: 1 kHz square into an NPN switch driving a red LED from 5 V
* probes: base col vled#branch
V1 drive 0 PULSE(0 3.3 0.1m 1u 1u 0.5m 1m)
Rb drive base 4.7k
Q1 col base 0 qnpn
.model qnpn NPN(IS=1e-14 BF=200 VAF=100 CJE=8p CJC=4p TF=0.4n)
Vcc vcc 0 DC 5
Vled vcc ledin DC 0
Rled ledin ledk 330
Dled ledk col dred
.model dred D(IS=1e-20 N=1.6 RS=2 CJO=20p)
.options reltol=1e-6 abstol=1e-12 vntol=1e-9
.tran 1u 3m 0 1u
.end
