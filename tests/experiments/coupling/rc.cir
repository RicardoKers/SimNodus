SimNodus E-03 GPIO-driven RC coupling fixture
Vdrive in 0 external
R1 in out 1k
C1 out 0 1u IC=0
.options reltol=1e-6 abstol=1e-12 vntol=1e-9 method=trap maxord=2
.save v(in) v(out)
.tran 1u 10m 0 1u uic
.end
